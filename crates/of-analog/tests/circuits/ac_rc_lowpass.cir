RC low-pass filter, small-signal response
* compare: vm(out) vp(out)
V1 in 0 DC 0 AC 1
R1 in out 1k
C1 out 0 159n
.ac dec 10 10 1meg
.end
