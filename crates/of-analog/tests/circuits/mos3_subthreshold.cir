Level-3 NMOS transfer characteristic through weak inversion, no VMAX
* compare: i(vd)
VD d 0 0.1
VG g 0 0
M1 d g 0 0 n3 w=20u l=3u
.model n3 nmos level=3 vto=0.7 kp=40u gamma=0.4 phi=0.7 tox=25n nsub=2e16 theta=0.1 eta=0.05 kappa=0.5 nfs=5e11 xj=0.3u
.dc VG 0 2 0.02
.end
