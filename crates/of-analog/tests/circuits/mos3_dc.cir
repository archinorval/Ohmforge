Level-3 NMOS output characteristics (nested DC sweep)
* compare: i(vd)
VD d 0 0
VG g 0 0
VB b 0 -1
M1 d g 0 b n3 w=10u l=2u
.model n3 nmos level=3 vto=0.8 kp=60u gamma=0.5 phi=0.7 tox=20n nsub=1e16 theta=0.06 eta=0.1 kappa=0.3 vmax=1.5e5 xj=0.2u nfs=1e11 delta=0.5 ld=0.1u
.dc VD 0 5 0.1 VG 1 3 0.5
.end
