NMOS source follower, body effect and bulk diodes in DC
* compare: v(s)
VDD d 0 5
VG g 0 0
M1 d g s 0 nch w=20u l=2u
RS s 0 10k
.model nch nmos level=1 vto=0.8 kp=100u gamma=0.6 phi=0.7 lambda=0.02 is=1e-14
.dc VG 0 5 0.05
.end
