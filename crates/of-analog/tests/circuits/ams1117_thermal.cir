AMS1117-3.3 macromodel: thermal limiting with a 3.3 ohm load as the input rises
* compare: v(out) v(xu1.tj)
.include ../../../../parts/regulators/ams1117/ams1117.lib
VIN in 0 4
XU1 in out 0 ams1117
RL out 0 3.3
.dc VIN 4 12 0.05
.end
