Zener clamp swept through breakdown
* compare: v(k)
V1 a 0 DC 0
R1 a k 220
D1 0 k dz
.model dz d is=1e-14 n=1 bv=5.6 ibv=5m rs=2
.dc V1 -3 12 0.1
.end
